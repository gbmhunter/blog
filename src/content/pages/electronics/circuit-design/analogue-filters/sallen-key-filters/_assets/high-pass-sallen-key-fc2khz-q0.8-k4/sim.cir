* High-pass Sallen-Key filter design example (fc = 2 kHz, Q = 0.8, K = 4)
* ----------------------------------------------------------------------------
* Verifies the corrected design-example component values from the page. Uses an
* ideal op-amp (constant high gain, no GBW rolloff) so this is the IDEAL
* response - exactly what the design equations predict. Run via main.py, which
* invokes ngspice in batch mode and plots the result.
*
* Topology (matches the page schematic):
*   in --C1-- a --C2-- p(+in);  R1: a..out (feedback);  R2: p..gnd (shunt)
*   non-inverting gain K = 1 + R3/R4

Vin in 0 dc 0 ac 1

C1 in a 10n
C2 a  p 10n
R1 a  out 12.4k
R2 p  0   4.99k

* Ideal op-amp: V(out) = A * (V(p) - V(fb)), A huge -> virtual short p = fb
Eopamp out 0 p fb 1e6

* Non-inverting gain network: K = 1 + R3/R4 = 1 + 3.01k/1k ~= 4
R3 out fb 3.01k
R4 fb  0  1k

.ac dec 200 10 1Meg

.control
set units = degrees
run
let mag   = db(v(out))
let phase = ph(v(out))
set wr_singlescale
set wr_vecnames
wrdata sim_out.data mag phase
.endc

.end
